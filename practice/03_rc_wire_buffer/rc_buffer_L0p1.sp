.title CMOS Buffer Signal Regeneration Simulation

* ==================================================
* 1. 電源與輸入訊號 (Power Supply & Input Signal)
* ==================================================
Vvdd vdd 0 DC 1.2V
Vin  in  0 PULSE(0V 1.2V 0n 0.1n 0.1n 5n 10n)

* ==================================================
* 2. 長導線 RC 衰減網路 (Wire Resistance & Parasitic Cap)
* ==================================================
Rwire in           in_degraded 20k
Cwire in_degraded 0           500fF

* ==================================================
* 3. 載入加密模型檔 (使用內建的 pmos / nmos 模型名稱)
* ==================================================
* MODEL_SETUP_REQUIRED
* ==================================================
* 4. 第一級 Inverter
* ==================================================
Mp1 out1 in_degraded vdd vdd pmos L=0.1u W=1.2u
Mn1 out1 in_degraded 0   0   nmos L=0.1u W=0.6u

* ==================================================
* 5. 第二級 Inverter (組成完整兩級 Buffer)
* ==================================================
Mp2 out  out1        vdd vdd pmos L=0.1u W=1.2u
Mn2 out  out1        0   0   nmos L=0.1u W=0.6u

* ==================================================
* 6. 時域模擬與波形輸出設定
* ==================================================
.tran 0.01n 30n
.probe v(in) v(in_degraded) v(out1) v(out)
.option post=2
.end
