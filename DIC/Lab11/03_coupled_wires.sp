DIC Lab 11: 03_coupled_wires
* MODEL_SETUP_REQUIRED
* Handout-based simulation at 1 V; this condition is not a model voltage rating.
.option post=2 nomod runlvl=6 measdgt=10 numdgt=10 ingold=2
.temp 27
.param VS=1
VDD vdd 0 'VS'
.subckt INV a y vp vn wn=0.6u wp=1.8u ll=0.25u
MN y a vn vn nmos W=wn L=ll
MP y a vp vp pmos W=wp L=ll
.ends INV
.param LEN=2000 RUNIT=0.17 CCUNIT=.08 CGUNIT=.07 CSUNIT=.14
.param CEN=1 LEFT=1 RIGHT=1
VBASE base 0 PWL(0 0 20n 0 20.1n 1 120n 1)
EIN in 0 VOL='(1-CEN)/2+CEN*V(base)'
EL il 0 VOL='(LEFT==2)?0:((1-LEFT)/2+LEFT*V(base))'
ER ir 0 VOL='(RIGHT==2)?0:((1-RIGHT)/2+RIGHT*V(base))'
XDl il l0 vdd 0 INV wn='5*WNBASE' wp='5*WPBASE' ll=LBASE
XRl l3 outl vdd 0 INV wn=WNBASE wp=WPBASE ll=LBASE
Rl0 l0 l1 'RUNIT*LEN/3'
Rl1 l1 l2 'RUNIT*LEN/3'
Rl2 l2 l3 'RUNIT*LEN/3'
Cl0 l0 0 'CSUNIT*LEN*1f/6'
Cl1 l1 0 'CSUNIT*LEN*1f/3'
Cl2 l2 0 'CSUNIT*LEN*1f/3'
Cl3 l3 0 'CSUNIT*LEN*1f/6'
XDc in c0 vdd 0 INV wn='5*WNBASE' wp='5*WPBASE' ll=LBASE
XRc c3 outc vdd 0 INV wn=WNBASE wp=WPBASE ll=LBASE
Rc0 c0 c1 'RUNIT*LEN/3'
Rc1 c1 c2 'RUNIT*LEN/3'
Rc2 c2 c3 'RUNIT*LEN/3'
Cc0 c0 0 'CGUNIT*LEN*1f/6'
Cc1 c1 0 'CGUNIT*LEN*1f/3'
Cc2 c2 0 'CGUNIT*LEN*1f/3'
Cc3 c3 0 'CGUNIT*LEN*1f/6'
XDr ir r0 vdd 0 INV wn='5*WNBASE' wp='5*WPBASE' ll=LBASE
XRr r3 outr vdd 0 INV wn=WNBASE wp=WPBASE ll=LBASE
Rr0 r0 r1 'RUNIT*LEN/3'
Rr1 r1 r2 'RUNIT*LEN/3'
Rr2 r2 r3 'RUNIT*LEN/3'
Cr0 r0 0 'CSUNIT*LEN*1f/6'
Cr1 r1 0 'CSUNIT*LEN*1f/3'
Cr2 r2 0 'CSUNIT*LEN*1f/3'
Cr3 r3 0 'CSUNIT*LEN*1f/6'
CCl0 l0 c0 'CCUNIT*LEN*1f/6'
CCl1 l1 c1 'CCUNIT*LEN*1f/3'
CCl2 l2 c2 'CCUNIT*LEN*1f/3'
CCl3 l3 c3 'CCUNIT*LEN*1f/6'
CCr0 r0 c0 'CCUNIT*LEN*1f/6'
CCr1 r1 c1 'CCUNIT*LEN*1f/3'
CCr2 r2 c2 'CCUNIT*LEN*1f/3'
CCr3 r3 c3 'CCUNIT*LEN*1f/6'
.tran 20p 120n
.print tran V(in) V(il) V(ir) V(outc)
.measure tran tin WHEN V(in)=0.5 CROSS=1
.measure tran tout WHEN V(outc)=0.5 CROSS=1
.measure tran delay PARAM='tout-tin'
.param LEN=2000 RUNIT=0.17 CCUNIT=0.08 CGUNIT=0.07 CSUNIT=0.14 CEN=1 LEFT=1 RIGHT=1 WNBASE=.9u WPBASE=2.7u LBASE=.35u
.temp 27

.alter case_001
.param LEN=4000 RUNIT=0.17 CCUNIT=0.08 CGUNIT=0.07 CSUNIT=0.14 CEN=1 LEFT=1 RIGHT=1 WNBASE=.9u WPBASE=2.7u LBASE=.35u
.temp 27

.alter case_002
.param LEN=6000 RUNIT=0.17 CCUNIT=0.08 CGUNIT=0.07 CSUNIT=0.14 CEN=1 LEFT=1 RIGHT=1 WNBASE=.9u WPBASE=2.7u LBASE=.35u
.temp 27

.alter case_003
.param LEN=8000 RUNIT=0.17 CCUNIT=0.08 CGUNIT=0.07 CSUNIT=0.14 CEN=1 LEFT=1 RIGHT=1 WNBASE=.9u WPBASE=2.7u LBASE=.35u
.temp 27

.alter case_004
.param LEN=10000 RUNIT=0.17 CCUNIT=0.08 CGUNIT=0.07 CSUNIT=0.14 CEN=1 LEFT=1 RIGHT=1 WNBASE=.9u WPBASE=2.7u LBASE=.35u
.temp 27

.alter case_005
.param LEN=2000 RUNIT=0.17 CCUNIT=0.08 CGUNIT=0.07 CSUNIT=0.14 CEN=1 LEFT=1 RIGHT=2 WNBASE=.9u WPBASE=2.7u LBASE=.35u
.temp 27

.alter case_006
.param LEN=4000 RUNIT=0.17 CCUNIT=0.08 CGUNIT=0.07 CSUNIT=0.14 CEN=1 LEFT=1 RIGHT=2 WNBASE=.9u WPBASE=2.7u LBASE=.35u
.temp 27

.alter case_007
.param LEN=6000 RUNIT=0.17 CCUNIT=0.08 CGUNIT=0.07 CSUNIT=0.14 CEN=1 LEFT=1 RIGHT=2 WNBASE=.9u WPBASE=2.7u LBASE=.35u
.temp 27

.alter case_008
.param LEN=8000 RUNIT=0.17 CCUNIT=0.08 CGUNIT=0.07 CSUNIT=0.14 CEN=1 LEFT=1 RIGHT=2 WNBASE=.9u WPBASE=2.7u LBASE=.35u
.temp 27

.alter case_009
.param LEN=10000 RUNIT=0.17 CCUNIT=0.08 CGUNIT=0.07 CSUNIT=0.14 CEN=1 LEFT=1 RIGHT=2 WNBASE=.9u WPBASE=2.7u LBASE=.35u
.temp 27

.alter case_010
.param LEN=2000 RUNIT=0.17 CCUNIT=0.08 CGUNIT=0.07 CSUNIT=0.14 CEN=1 LEFT=1 RIGHT=-1 WNBASE=.9u WPBASE=2.7u LBASE=.35u
.temp 27

.alter case_011
.param LEN=4000 RUNIT=0.17 CCUNIT=0.08 CGUNIT=0.07 CSUNIT=0.14 CEN=1 LEFT=1 RIGHT=-1 WNBASE=.9u WPBASE=2.7u LBASE=.35u
.temp 27

.alter case_012
.param LEN=6000 RUNIT=0.17 CCUNIT=0.08 CGUNIT=0.07 CSUNIT=0.14 CEN=1 LEFT=1 RIGHT=-1 WNBASE=.9u WPBASE=2.7u LBASE=.35u
.temp 27

.alter case_013
.param LEN=8000 RUNIT=0.17 CCUNIT=0.08 CGUNIT=0.07 CSUNIT=0.14 CEN=1 LEFT=1 RIGHT=-1 WNBASE=.9u WPBASE=2.7u LBASE=.35u
.temp 27

.alter case_014
.param LEN=10000 RUNIT=0.17 CCUNIT=0.08 CGUNIT=0.07 CSUNIT=0.14 CEN=1 LEFT=1 RIGHT=-1 WNBASE=.9u WPBASE=2.7u LBASE=.35u
.temp 27

.alter case_015
.param LEN=2000 RUNIT=0.17 CCUNIT=0.08 CGUNIT=0.07 CSUNIT=0.14 CEN=1 LEFT=2 RIGHT=2 WNBASE=.9u WPBASE=2.7u LBASE=.35u
.temp 27

.alter case_016
.param LEN=4000 RUNIT=0.17 CCUNIT=0.08 CGUNIT=0.07 CSUNIT=0.14 CEN=1 LEFT=2 RIGHT=2 WNBASE=.9u WPBASE=2.7u LBASE=.35u
.temp 27

.alter case_017
.param LEN=6000 RUNIT=0.17 CCUNIT=0.08 CGUNIT=0.07 CSUNIT=0.14 CEN=1 LEFT=2 RIGHT=2 WNBASE=.9u WPBASE=2.7u LBASE=.35u
.temp 27

.alter case_018
.param LEN=8000 RUNIT=0.17 CCUNIT=0.08 CGUNIT=0.07 CSUNIT=0.14 CEN=1 LEFT=2 RIGHT=2 WNBASE=.9u WPBASE=2.7u LBASE=.35u
.temp 27

.alter case_019
.param LEN=10000 RUNIT=0.17 CCUNIT=0.08 CGUNIT=0.07 CSUNIT=0.14 CEN=1 LEFT=2 RIGHT=2 WNBASE=.9u WPBASE=2.7u LBASE=.35u
.temp 27

.alter case_020
.param LEN=2000 RUNIT=0.17 CCUNIT=0.08 CGUNIT=0.07 CSUNIT=0.14 CEN=1 LEFT=2 RIGHT=-1 WNBASE=.9u WPBASE=2.7u LBASE=.35u
.temp 27

.alter case_021
.param LEN=4000 RUNIT=0.17 CCUNIT=0.08 CGUNIT=0.07 CSUNIT=0.14 CEN=1 LEFT=2 RIGHT=-1 WNBASE=.9u WPBASE=2.7u LBASE=.35u
.temp 27

.alter case_022
.param LEN=6000 RUNIT=0.17 CCUNIT=0.08 CGUNIT=0.07 CSUNIT=0.14 CEN=1 LEFT=2 RIGHT=-1 WNBASE=.9u WPBASE=2.7u LBASE=.35u
.temp 27

.alter case_023
.param LEN=8000 RUNIT=0.17 CCUNIT=0.08 CGUNIT=0.07 CSUNIT=0.14 CEN=1 LEFT=2 RIGHT=-1 WNBASE=.9u WPBASE=2.7u LBASE=.35u
.temp 27

.alter case_024
.param LEN=10000 RUNIT=0.17 CCUNIT=0.08 CGUNIT=0.07 CSUNIT=0.14 CEN=1 LEFT=2 RIGHT=-1 WNBASE=.9u WPBASE=2.7u LBASE=.35u
.temp 27

.alter case_025
.param LEN=2000 RUNIT=0.17 CCUNIT=0.08 CGUNIT=0.07 CSUNIT=0.14 CEN=1 LEFT=-1 RIGHT=-1 WNBASE=.9u WPBASE=2.7u LBASE=.35u
.temp 27

.alter case_026
.param LEN=4000 RUNIT=0.17 CCUNIT=0.08 CGUNIT=0.07 CSUNIT=0.14 CEN=1 LEFT=-1 RIGHT=-1 WNBASE=.9u WPBASE=2.7u LBASE=.35u
.temp 27

.alter case_027
.param LEN=6000 RUNIT=0.17 CCUNIT=0.08 CGUNIT=0.07 CSUNIT=0.14 CEN=1 LEFT=-1 RIGHT=-1 WNBASE=.9u WPBASE=2.7u LBASE=.35u
.temp 27

.alter case_028
.param LEN=8000 RUNIT=0.17 CCUNIT=0.08 CGUNIT=0.07 CSUNIT=0.14 CEN=1 LEFT=-1 RIGHT=-1 WNBASE=.9u WPBASE=2.7u LBASE=.35u
.temp 27

.alter case_029
.param LEN=10000 RUNIT=0.17 CCUNIT=0.08 CGUNIT=0.07 CSUNIT=0.14 CEN=1 LEFT=-1 RIGHT=-1 WNBASE=.9u WPBASE=2.7u LBASE=.35u
.temp 27

.alter case_030
.param LEN=2000 RUNIT=0.17 CCUNIT=0.08 CGUNIT=0.07 CSUNIT=0.14 CEN=-1 LEFT=1 RIGHT=1 WNBASE=.9u WPBASE=2.7u LBASE=.35u
.temp 27

.alter case_031
.param LEN=4000 RUNIT=0.17 CCUNIT=0.08 CGUNIT=0.07 CSUNIT=0.14 CEN=-1 LEFT=1 RIGHT=1 WNBASE=.9u WPBASE=2.7u LBASE=.35u
.temp 27

.alter case_032
.param LEN=6000 RUNIT=0.17 CCUNIT=0.08 CGUNIT=0.07 CSUNIT=0.14 CEN=-1 LEFT=1 RIGHT=1 WNBASE=.9u WPBASE=2.7u LBASE=.35u
.temp 27

.alter case_033
.param LEN=8000 RUNIT=0.17 CCUNIT=0.08 CGUNIT=0.07 CSUNIT=0.14 CEN=-1 LEFT=1 RIGHT=1 WNBASE=.9u WPBASE=2.7u LBASE=.35u
.temp 27

.alter case_034
.param LEN=10000 RUNIT=0.17 CCUNIT=0.08 CGUNIT=0.07 CSUNIT=0.14 CEN=-1 LEFT=1 RIGHT=1 WNBASE=.9u WPBASE=2.7u LBASE=.35u
.temp 27

.alter case_035
.param LEN=2000 RUNIT=0.17 CCUNIT=0.08 CGUNIT=0.07 CSUNIT=0.14 CEN=-1 LEFT=1 RIGHT=2 WNBASE=.9u WPBASE=2.7u LBASE=.35u
.temp 27

.alter case_036
.param LEN=4000 RUNIT=0.17 CCUNIT=0.08 CGUNIT=0.07 CSUNIT=0.14 CEN=-1 LEFT=1 RIGHT=2 WNBASE=.9u WPBASE=2.7u LBASE=.35u
.temp 27

.alter case_037
.param LEN=6000 RUNIT=0.17 CCUNIT=0.08 CGUNIT=0.07 CSUNIT=0.14 CEN=-1 LEFT=1 RIGHT=2 WNBASE=.9u WPBASE=2.7u LBASE=.35u
.temp 27

.alter case_038
.param LEN=8000 RUNIT=0.17 CCUNIT=0.08 CGUNIT=0.07 CSUNIT=0.14 CEN=-1 LEFT=1 RIGHT=2 WNBASE=.9u WPBASE=2.7u LBASE=.35u
.temp 27

.alter case_039
.param LEN=10000 RUNIT=0.17 CCUNIT=0.08 CGUNIT=0.07 CSUNIT=0.14 CEN=-1 LEFT=1 RIGHT=2 WNBASE=.9u WPBASE=2.7u LBASE=.35u
.temp 27

.alter case_040
.param LEN=2000 RUNIT=0.17 CCUNIT=0.08 CGUNIT=0.07 CSUNIT=0.14 CEN=-1 LEFT=1 RIGHT=-1 WNBASE=.9u WPBASE=2.7u LBASE=.35u
.temp 27

.alter case_041
.param LEN=4000 RUNIT=0.17 CCUNIT=0.08 CGUNIT=0.07 CSUNIT=0.14 CEN=-1 LEFT=1 RIGHT=-1 WNBASE=.9u WPBASE=2.7u LBASE=.35u
.temp 27

.alter case_042
.param LEN=6000 RUNIT=0.17 CCUNIT=0.08 CGUNIT=0.07 CSUNIT=0.14 CEN=-1 LEFT=1 RIGHT=-1 WNBASE=.9u WPBASE=2.7u LBASE=.35u
.temp 27

.alter case_043
.param LEN=8000 RUNIT=0.17 CCUNIT=0.08 CGUNIT=0.07 CSUNIT=0.14 CEN=-1 LEFT=1 RIGHT=-1 WNBASE=.9u WPBASE=2.7u LBASE=.35u
.temp 27

.alter case_044
.param LEN=10000 RUNIT=0.17 CCUNIT=0.08 CGUNIT=0.07 CSUNIT=0.14 CEN=-1 LEFT=1 RIGHT=-1 WNBASE=.9u WPBASE=2.7u LBASE=.35u
.temp 27

.alter case_045
.param LEN=2000 RUNIT=0.17 CCUNIT=0.08 CGUNIT=0.07 CSUNIT=0.14 CEN=-1 LEFT=2 RIGHT=2 WNBASE=.9u WPBASE=2.7u LBASE=.35u
.temp 27

.alter case_046
.param LEN=4000 RUNIT=0.17 CCUNIT=0.08 CGUNIT=0.07 CSUNIT=0.14 CEN=-1 LEFT=2 RIGHT=2 WNBASE=.9u WPBASE=2.7u LBASE=.35u
.temp 27

.alter case_047
.param LEN=6000 RUNIT=0.17 CCUNIT=0.08 CGUNIT=0.07 CSUNIT=0.14 CEN=-1 LEFT=2 RIGHT=2 WNBASE=.9u WPBASE=2.7u LBASE=.35u
.temp 27

.alter case_048
.param LEN=8000 RUNIT=0.17 CCUNIT=0.08 CGUNIT=0.07 CSUNIT=0.14 CEN=-1 LEFT=2 RIGHT=2 WNBASE=.9u WPBASE=2.7u LBASE=.35u
.temp 27

.alter case_049
.param LEN=10000 RUNIT=0.17 CCUNIT=0.08 CGUNIT=0.07 CSUNIT=0.14 CEN=-1 LEFT=2 RIGHT=2 WNBASE=.9u WPBASE=2.7u LBASE=.35u
.temp 27

.alter case_050
.param LEN=2000 RUNIT=0.17 CCUNIT=0.08 CGUNIT=0.07 CSUNIT=0.14 CEN=-1 LEFT=2 RIGHT=-1 WNBASE=.9u WPBASE=2.7u LBASE=.35u
.temp 27

.alter case_051
.param LEN=4000 RUNIT=0.17 CCUNIT=0.08 CGUNIT=0.07 CSUNIT=0.14 CEN=-1 LEFT=2 RIGHT=-1 WNBASE=.9u WPBASE=2.7u LBASE=.35u
.temp 27

.alter case_052
.param LEN=6000 RUNIT=0.17 CCUNIT=0.08 CGUNIT=0.07 CSUNIT=0.14 CEN=-1 LEFT=2 RIGHT=-1 WNBASE=.9u WPBASE=2.7u LBASE=.35u
.temp 27

.alter case_053
.param LEN=8000 RUNIT=0.17 CCUNIT=0.08 CGUNIT=0.07 CSUNIT=0.14 CEN=-1 LEFT=2 RIGHT=-1 WNBASE=.9u WPBASE=2.7u LBASE=.35u
.temp 27

.alter case_054
.param LEN=10000 RUNIT=0.17 CCUNIT=0.08 CGUNIT=0.07 CSUNIT=0.14 CEN=-1 LEFT=2 RIGHT=-1 WNBASE=.9u WPBASE=2.7u LBASE=.35u
.temp 27

.alter case_055
.param LEN=2000 RUNIT=0.17 CCUNIT=0.08 CGUNIT=0.07 CSUNIT=0.14 CEN=-1 LEFT=-1 RIGHT=-1 WNBASE=.9u WPBASE=2.7u LBASE=.35u
.temp 27

.alter case_056
.param LEN=4000 RUNIT=0.17 CCUNIT=0.08 CGUNIT=0.07 CSUNIT=0.14 CEN=-1 LEFT=-1 RIGHT=-1 WNBASE=.9u WPBASE=2.7u LBASE=.35u
.temp 27

.alter case_057
.param LEN=6000 RUNIT=0.17 CCUNIT=0.08 CGUNIT=0.07 CSUNIT=0.14 CEN=-1 LEFT=-1 RIGHT=-1 WNBASE=.9u WPBASE=2.7u LBASE=.35u
.temp 27

.alter case_058
.param LEN=8000 RUNIT=0.17 CCUNIT=0.08 CGUNIT=0.07 CSUNIT=0.14 CEN=-1 LEFT=-1 RIGHT=-1 WNBASE=.9u WPBASE=2.7u LBASE=.35u
.temp 27

.alter case_059
.param LEN=10000 RUNIT=0.17 CCUNIT=0.08 CGUNIT=0.07 CSUNIT=0.14 CEN=-1 LEFT=-1 RIGHT=-1 WNBASE=.9u WPBASE=2.7u LBASE=.35u
.temp 27

.alter case_060
.param LEN=2000 RUNIT=0.24 CCUNIT=0.09 CGUNIT=0.05 CSUNIT=0.14 CEN=1 LEFT=1 RIGHT=1 WNBASE=.6u WPBASE=1.8u LBASE=.25u
.temp 27

.alter case_061
.param LEN=4000 RUNIT=0.24 CCUNIT=0.09 CGUNIT=0.05 CSUNIT=0.14 CEN=1 LEFT=1 RIGHT=1 WNBASE=.6u WPBASE=1.8u LBASE=.25u
.temp 27

.alter case_062
.param LEN=6000 RUNIT=0.24 CCUNIT=0.09 CGUNIT=0.05 CSUNIT=0.14 CEN=1 LEFT=1 RIGHT=1 WNBASE=.6u WPBASE=1.8u LBASE=.25u
.temp 27

.alter case_063
.param LEN=8000 RUNIT=0.24 CCUNIT=0.09 CGUNIT=0.05 CSUNIT=0.14 CEN=1 LEFT=1 RIGHT=1 WNBASE=.6u WPBASE=1.8u LBASE=.25u
.temp 27

.alter case_064
.param LEN=10000 RUNIT=0.24 CCUNIT=0.09 CGUNIT=0.05 CSUNIT=0.14 CEN=1 LEFT=1 RIGHT=1 WNBASE=.6u WPBASE=1.8u LBASE=.25u
.temp 27

.alter case_065
.param LEN=2000 RUNIT=0.24 CCUNIT=0.09 CGUNIT=0.05 CSUNIT=0.14 CEN=1 LEFT=1 RIGHT=2 WNBASE=.6u WPBASE=1.8u LBASE=.25u
.temp 27

.alter case_066
.param LEN=4000 RUNIT=0.24 CCUNIT=0.09 CGUNIT=0.05 CSUNIT=0.14 CEN=1 LEFT=1 RIGHT=2 WNBASE=.6u WPBASE=1.8u LBASE=.25u
.temp 27

.alter case_067
.param LEN=6000 RUNIT=0.24 CCUNIT=0.09 CGUNIT=0.05 CSUNIT=0.14 CEN=1 LEFT=1 RIGHT=2 WNBASE=.6u WPBASE=1.8u LBASE=.25u
.temp 27

.alter case_068
.param LEN=8000 RUNIT=0.24 CCUNIT=0.09 CGUNIT=0.05 CSUNIT=0.14 CEN=1 LEFT=1 RIGHT=2 WNBASE=.6u WPBASE=1.8u LBASE=.25u
.temp 27

.alter case_069
.param LEN=10000 RUNIT=0.24 CCUNIT=0.09 CGUNIT=0.05 CSUNIT=0.14 CEN=1 LEFT=1 RIGHT=2 WNBASE=.6u WPBASE=1.8u LBASE=.25u
.temp 27

.alter case_070
.param LEN=2000 RUNIT=0.24 CCUNIT=0.09 CGUNIT=0.05 CSUNIT=0.14 CEN=1 LEFT=1 RIGHT=-1 WNBASE=.6u WPBASE=1.8u LBASE=.25u
.temp 27

.alter case_071
.param LEN=4000 RUNIT=0.24 CCUNIT=0.09 CGUNIT=0.05 CSUNIT=0.14 CEN=1 LEFT=1 RIGHT=-1 WNBASE=.6u WPBASE=1.8u LBASE=.25u
.temp 27

.alter case_072
.param LEN=6000 RUNIT=0.24 CCUNIT=0.09 CGUNIT=0.05 CSUNIT=0.14 CEN=1 LEFT=1 RIGHT=-1 WNBASE=.6u WPBASE=1.8u LBASE=.25u
.temp 27

.alter case_073
.param LEN=8000 RUNIT=0.24 CCUNIT=0.09 CGUNIT=0.05 CSUNIT=0.14 CEN=1 LEFT=1 RIGHT=-1 WNBASE=.6u WPBASE=1.8u LBASE=.25u
.temp 27

.alter case_074
.param LEN=10000 RUNIT=0.24 CCUNIT=0.09 CGUNIT=0.05 CSUNIT=0.14 CEN=1 LEFT=1 RIGHT=-1 WNBASE=.6u WPBASE=1.8u LBASE=.25u
.temp 27

.alter case_075
.param LEN=2000 RUNIT=0.24 CCUNIT=0.09 CGUNIT=0.05 CSUNIT=0.14 CEN=1 LEFT=2 RIGHT=2 WNBASE=.6u WPBASE=1.8u LBASE=.25u
.temp 27

.alter case_076
.param LEN=4000 RUNIT=0.24 CCUNIT=0.09 CGUNIT=0.05 CSUNIT=0.14 CEN=1 LEFT=2 RIGHT=2 WNBASE=.6u WPBASE=1.8u LBASE=.25u
.temp 27

.alter case_077
.param LEN=6000 RUNIT=0.24 CCUNIT=0.09 CGUNIT=0.05 CSUNIT=0.14 CEN=1 LEFT=2 RIGHT=2 WNBASE=.6u WPBASE=1.8u LBASE=.25u
.temp 27

.alter case_078
.param LEN=8000 RUNIT=0.24 CCUNIT=0.09 CGUNIT=0.05 CSUNIT=0.14 CEN=1 LEFT=2 RIGHT=2 WNBASE=.6u WPBASE=1.8u LBASE=.25u
.temp 27

.alter case_079
.param LEN=10000 RUNIT=0.24 CCUNIT=0.09 CGUNIT=0.05 CSUNIT=0.14 CEN=1 LEFT=2 RIGHT=2 WNBASE=.6u WPBASE=1.8u LBASE=.25u
.temp 27

.alter case_080
.param LEN=2000 RUNIT=0.24 CCUNIT=0.09 CGUNIT=0.05 CSUNIT=0.14 CEN=1 LEFT=2 RIGHT=-1 WNBASE=.6u WPBASE=1.8u LBASE=.25u
.temp 27

.alter case_081
.param LEN=4000 RUNIT=0.24 CCUNIT=0.09 CGUNIT=0.05 CSUNIT=0.14 CEN=1 LEFT=2 RIGHT=-1 WNBASE=.6u WPBASE=1.8u LBASE=.25u
.temp 27

.alter case_082
.param LEN=6000 RUNIT=0.24 CCUNIT=0.09 CGUNIT=0.05 CSUNIT=0.14 CEN=1 LEFT=2 RIGHT=-1 WNBASE=.6u WPBASE=1.8u LBASE=.25u
.temp 27

.alter case_083
.param LEN=8000 RUNIT=0.24 CCUNIT=0.09 CGUNIT=0.05 CSUNIT=0.14 CEN=1 LEFT=2 RIGHT=-1 WNBASE=.6u WPBASE=1.8u LBASE=.25u
.temp 27

.alter case_084
.param LEN=10000 RUNIT=0.24 CCUNIT=0.09 CGUNIT=0.05 CSUNIT=0.14 CEN=1 LEFT=2 RIGHT=-1 WNBASE=.6u WPBASE=1.8u LBASE=.25u
.temp 27

.alter case_085
.param LEN=2000 RUNIT=0.24 CCUNIT=0.09 CGUNIT=0.05 CSUNIT=0.14 CEN=1 LEFT=-1 RIGHT=-1 WNBASE=.6u WPBASE=1.8u LBASE=.25u
.temp 27

.alter case_086
.param LEN=4000 RUNIT=0.24 CCUNIT=0.09 CGUNIT=0.05 CSUNIT=0.14 CEN=1 LEFT=-1 RIGHT=-1 WNBASE=.6u WPBASE=1.8u LBASE=.25u
.temp 27

.alter case_087
.param LEN=6000 RUNIT=0.24 CCUNIT=0.09 CGUNIT=0.05 CSUNIT=0.14 CEN=1 LEFT=-1 RIGHT=-1 WNBASE=.6u WPBASE=1.8u LBASE=.25u
.temp 27

.alter case_088
.param LEN=8000 RUNIT=0.24 CCUNIT=0.09 CGUNIT=0.05 CSUNIT=0.14 CEN=1 LEFT=-1 RIGHT=-1 WNBASE=.6u WPBASE=1.8u LBASE=.25u
.temp 27

.alter case_089
.param LEN=10000 RUNIT=0.24 CCUNIT=0.09 CGUNIT=0.05 CSUNIT=0.14 CEN=1 LEFT=-1 RIGHT=-1 WNBASE=.6u WPBASE=1.8u LBASE=.25u
.temp 27

.alter case_090
.param LEN=2000 RUNIT=0.24 CCUNIT=0.09 CGUNIT=0.05 CSUNIT=0.14 CEN=-1 LEFT=1 RIGHT=1 WNBASE=.6u WPBASE=1.8u LBASE=.25u
.temp 27

.alter case_091
.param LEN=4000 RUNIT=0.24 CCUNIT=0.09 CGUNIT=0.05 CSUNIT=0.14 CEN=-1 LEFT=1 RIGHT=1 WNBASE=.6u WPBASE=1.8u LBASE=.25u
.temp 27

.alter case_092
.param LEN=6000 RUNIT=0.24 CCUNIT=0.09 CGUNIT=0.05 CSUNIT=0.14 CEN=-1 LEFT=1 RIGHT=1 WNBASE=.6u WPBASE=1.8u LBASE=.25u
.temp 27

.alter case_093
.param LEN=8000 RUNIT=0.24 CCUNIT=0.09 CGUNIT=0.05 CSUNIT=0.14 CEN=-1 LEFT=1 RIGHT=1 WNBASE=.6u WPBASE=1.8u LBASE=.25u
.temp 27

.alter case_094
.param LEN=10000 RUNIT=0.24 CCUNIT=0.09 CGUNIT=0.05 CSUNIT=0.14 CEN=-1 LEFT=1 RIGHT=1 WNBASE=.6u WPBASE=1.8u LBASE=.25u
.temp 27

.alter case_095
.param LEN=2000 RUNIT=0.24 CCUNIT=0.09 CGUNIT=0.05 CSUNIT=0.14 CEN=-1 LEFT=1 RIGHT=2 WNBASE=.6u WPBASE=1.8u LBASE=.25u
.temp 27

.alter case_096
.param LEN=4000 RUNIT=0.24 CCUNIT=0.09 CGUNIT=0.05 CSUNIT=0.14 CEN=-1 LEFT=1 RIGHT=2 WNBASE=.6u WPBASE=1.8u LBASE=.25u
.temp 27

.alter case_097
.param LEN=6000 RUNIT=0.24 CCUNIT=0.09 CGUNIT=0.05 CSUNIT=0.14 CEN=-1 LEFT=1 RIGHT=2 WNBASE=.6u WPBASE=1.8u LBASE=.25u
.temp 27

.alter case_098
.param LEN=8000 RUNIT=0.24 CCUNIT=0.09 CGUNIT=0.05 CSUNIT=0.14 CEN=-1 LEFT=1 RIGHT=2 WNBASE=.6u WPBASE=1.8u LBASE=.25u
.temp 27

.alter case_099
.param LEN=10000 RUNIT=0.24 CCUNIT=0.09 CGUNIT=0.05 CSUNIT=0.14 CEN=-1 LEFT=1 RIGHT=2 WNBASE=.6u WPBASE=1.8u LBASE=.25u
.temp 27

.alter case_100
.param LEN=2000 RUNIT=0.24 CCUNIT=0.09 CGUNIT=0.05 CSUNIT=0.14 CEN=-1 LEFT=1 RIGHT=-1 WNBASE=.6u WPBASE=1.8u LBASE=.25u
.temp 27

.alter case_101
.param LEN=4000 RUNIT=0.24 CCUNIT=0.09 CGUNIT=0.05 CSUNIT=0.14 CEN=-1 LEFT=1 RIGHT=-1 WNBASE=.6u WPBASE=1.8u LBASE=.25u
.temp 27

.alter case_102
.param LEN=6000 RUNIT=0.24 CCUNIT=0.09 CGUNIT=0.05 CSUNIT=0.14 CEN=-1 LEFT=1 RIGHT=-1 WNBASE=.6u WPBASE=1.8u LBASE=.25u
.temp 27

.alter case_103
.param LEN=8000 RUNIT=0.24 CCUNIT=0.09 CGUNIT=0.05 CSUNIT=0.14 CEN=-1 LEFT=1 RIGHT=-1 WNBASE=.6u WPBASE=1.8u LBASE=.25u
.temp 27

.alter case_104
.param LEN=10000 RUNIT=0.24 CCUNIT=0.09 CGUNIT=0.05 CSUNIT=0.14 CEN=-1 LEFT=1 RIGHT=-1 WNBASE=.6u WPBASE=1.8u LBASE=.25u
.temp 27

.alter case_105
.param LEN=2000 RUNIT=0.24 CCUNIT=0.09 CGUNIT=0.05 CSUNIT=0.14 CEN=-1 LEFT=2 RIGHT=2 WNBASE=.6u WPBASE=1.8u LBASE=.25u
.temp 27

.alter case_106
.param LEN=4000 RUNIT=0.24 CCUNIT=0.09 CGUNIT=0.05 CSUNIT=0.14 CEN=-1 LEFT=2 RIGHT=2 WNBASE=.6u WPBASE=1.8u LBASE=.25u
.temp 27

.alter case_107
.param LEN=6000 RUNIT=0.24 CCUNIT=0.09 CGUNIT=0.05 CSUNIT=0.14 CEN=-1 LEFT=2 RIGHT=2 WNBASE=.6u WPBASE=1.8u LBASE=.25u
.temp 27

.alter case_108
.param LEN=8000 RUNIT=0.24 CCUNIT=0.09 CGUNIT=0.05 CSUNIT=0.14 CEN=-1 LEFT=2 RIGHT=2 WNBASE=.6u WPBASE=1.8u LBASE=.25u
.temp 27

.alter case_109
.param LEN=10000 RUNIT=0.24 CCUNIT=0.09 CGUNIT=0.05 CSUNIT=0.14 CEN=-1 LEFT=2 RIGHT=2 WNBASE=.6u WPBASE=1.8u LBASE=.25u
.temp 27

.alter case_110
.param LEN=2000 RUNIT=0.24 CCUNIT=0.09 CGUNIT=0.05 CSUNIT=0.14 CEN=-1 LEFT=2 RIGHT=-1 WNBASE=.6u WPBASE=1.8u LBASE=.25u
.temp 27

.alter case_111
.param LEN=4000 RUNIT=0.24 CCUNIT=0.09 CGUNIT=0.05 CSUNIT=0.14 CEN=-1 LEFT=2 RIGHT=-1 WNBASE=.6u WPBASE=1.8u LBASE=.25u
.temp 27

.alter case_112
.param LEN=6000 RUNIT=0.24 CCUNIT=0.09 CGUNIT=0.05 CSUNIT=0.14 CEN=-1 LEFT=2 RIGHT=-1 WNBASE=.6u WPBASE=1.8u LBASE=.25u
.temp 27

.alter case_113
.param LEN=8000 RUNIT=0.24 CCUNIT=0.09 CGUNIT=0.05 CSUNIT=0.14 CEN=-1 LEFT=2 RIGHT=-1 WNBASE=.6u WPBASE=1.8u LBASE=.25u
.temp 27

.alter case_114
.param LEN=10000 RUNIT=0.24 CCUNIT=0.09 CGUNIT=0.05 CSUNIT=0.14 CEN=-1 LEFT=2 RIGHT=-1 WNBASE=.6u WPBASE=1.8u LBASE=.25u
.temp 27

.alter case_115
.param LEN=2000 RUNIT=0.24 CCUNIT=0.09 CGUNIT=0.05 CSUNIT=0.14 CEN=-1 LEFT=-1 RIGHT=-1 WNBASE=.6u WPBASE=1.8u LBASE=.25u
.temp 27

.alter case_116
.param LEN=4000 RUNIT=0.24 CCUNIT=0.09 CGUNIT=0.05 CSUNIT=0.14 CEN=-1 LEFT=-1 RIGHT=-1 WNBASE=.6u WPBASE=1.8u LBASE=.25u
.temp 27

.alter case_117
.param LEN=6000 RUNIT=0.24 CCUNIT=0.09 CGUNIT=0.05 CSUNIT=0.14 CEN=-1 LEFT=-1 RIGHT=-1 WNBASE=.6u WPBASE=1.8u LBASE=.25u
.temp 27

.alter case_118
.param LEN=8000 RUNIT=0.24 CCUNIT=0.09 CGUNIT=0.05 CSUNIT=0.14 CEN=-1 LEFT=-1 RIGHT=-1 WNBASE=.6u WPBASE=1.8u LBASE=.25u
.temp 27

.alter case_119
.param LEN=10000 RUNIT=0.24 CCUNIT=0.09 CGUNIT=0.05 CSUNIT=0.14 CEN=-1 LEFT=-1 RIGHT=-1 WNBASE=.6u WPBASE=1.8u LBASE=.25u
.temp 27

.alter case_120
.param LEN=2000 RUNIT=0.34 CCUNIT=0.1 CGUNIT=0.04 CSUNIT=0.14 CEN=1 LEFT=1 RIGHT=1 WNBASE=.5u WPBASE=1.5u LBASE=.18u
.temp 27

.alter case_121
.param LEN=4000 RUNIT=0.34 CCUNIT=0.1 CGUNIT=0.04 CSUNIT=0.14 CEN=1 LEFT=1 RIGHT=1 WNBASE=.5u WPBASE=1.5u LBASE=.18u
.temp 27

.alter case_122
.param LEN=6000 RUNIT=0.34 CCUNIT=0.1 CGUNIT=0.04 CSUNIT=0.14 CEN=1 LEFT=1 RIGHT=1 WNBASE=.5u WPBASE=1.5u LBASE=.18u
.temp 27

.alter case_123
.param LEN=8000 RUNIT=0.34 CCUNIT=0.1 CGUNIT=0.04 CSUNIT=0.14 CEN=1 LEFT=1 RIGHT=1 WNBASE=.5u WPBASE=1.5u LBASE=.18u
.temp 27

.alter case_124
.param LEN=10000 RUNIT=0.34 CCUNIT=0.1 CGUNIT=0.04 CSUNIT=0.14 CEN=1 LEFT=1 RIGHT=1 WNBASE=.5u WPBASE=1.5u LBASE=.18u
.temp 27

.alter case_125
.param LEN=2000 RUNIT=0.34 CCUNIT=0.1 CGUNIT=0.04 CSUNIT=0.14 CEN=1 LEFT=1 RIGHT=2 WNBASE=.5u WPBASE=1.5u LBASE=.18u
.temp 27

.alter case_126
.param LEN=4000 RUNIT=0.34 CCUNIT=0.1 CGUNIT=0.04 CSUNIT=0.14 CEN=1 LEFT=1 RIGHT=2 WNBASE=.5u WPBASE=1.5u LBASE=.18u
.temp 27

.alter case_127
.param LEN=6000 RUNIT=0.34 CCUNIT=0.1 CGUNIT=0.04 CSUNIT=0.14 CEN=1 LEFT=1 RIGHT=2 WNBASE=.5u WPBASE=1.5u LBASE=.18u
.temp 27

.alter case_128
.param LEN=8000 RUNIT=0.34 CCUNIT=0.1 CGUNIT=0.04 CSUNIT=0.14 CEN=1 LEFT=1 RIGHT=2 WNBASE=.5u WPBASE=1.5u LBASE=.18u
.temp 27

.alter case_129
.param LEN=10000 RUNIT=0.34 CCUNIT=0.1 CGUNIT=0.04 CSUNIT=0.14 CEN=1 LEFT=1 RIGHT=2 WNBASE=.5u WPBASE=1.5u LBASE=.18u
.temp 27

.alter case_130
.param LEN=2000 RUNIT=0.34 CCUNIT=0.1 CGUNIT=0.04 CSUNIT=0.14 CEN=1 LEFT=1 RIGHT=-1 WNBASE=.5u WPBASE=1.5u LBASE=.18u
.temp 27

.alter case_131
.param LEN=4000 RUNIT=0.34 CCUNIT=0.1 CGUNIT=0.04 CSUNIT=0.14 CEN=1 LEFT=1 RIGHT=-1 WNBASE=.5u WPBASE=1.5u LBASE=.18u
.temp 27

.alter case_132
.param LEN=6000 RUNIT=0.34 CCUNIT=0.1 CGUNIT=0.04 CSUNIT=0.14 CEN=1 LEFT=1 RIGHT=-1 WNBASE=.5u WPBASE=1.5u LBASE=.18u
.temp 27

.alter case_133
.param LEN=8000 RUNIT=0.34 CCUNIT=0.1 CGUNIT=0.04 CSUNIT=0.14 CEN=1 LEFT=1 RIGHT=-1 WNBASE=.5u WPBASE=1.5u LBASE=.18u
.temp 27

.alter case_134
.param LEN=10000 RUNIT=0.34 CCUNIT=0.1 CGUNIT=0.04 CSUNIT=0.14 CEN=1 LEFT=1 RIGHT=-1 WNBASE=.5u WPBASE=1.5u LBASE=.18u
.temp 27

.alter case_135
.param LEN=2000 RUNIT=0.34 CCUNIT=0.1 CGUNIT=0.04 CSUNIT=0.14 CEN=1 LEFT=2 RIGHT=2 WNBASE=.5u WPBASE=1.5u LBASE=.18u
.temp 27

.alter case_136
.param LEN=4000 RUNIT=0.34 CCUNIT=0.1 CGUNIT=0.04 CSUNIT=0.14 CEN=1 LEFT=2 RIGHT=2 WNBASE=.5u WPBASE=1.5u LBASE=.18u
.temp 27

.alter case_137
.param LEN=6000 RUNIT=0.34 CCUNIT=0.1 CGUNIT=0.04 CSUNIT=0.14 CEN=1 LEFT=2 RIGHT=2 WNBASE=.5u WPBASE=1.5u LBASE=.18u
.temp 27

.alter case_138
.param LEN=8000 RUNIT=0.34 CCUNIT=0.1 CGUNIT=0.04 CSUNIT=0.14 CEN=1 LEFT=2 RIGHT=2 WNBASE=.5u WPBASE=1.5u LBASE=.18u
.temp 27

.alter case_139
.param LEN=10000 RUNIT=0.34 CCUNIT=0.1 CGUNIT=0.04 CSUNIT=0.14 CEN=1 LEFT=2 RIGHT=2 WNBASE=.5u WPBASE=1.5u LBASE=.18u
.temp 27

.alter case_140
.param LEN=2000 RUNIT=0.34 CCUNIT=0.1 CGUNIT=0.04 CSUNIT=0.14 CEN=1 LEFT=2 RIGHT=-1 WNBASE=.5u WPBASE=1.5u LBASE=.18u
.temp 27

.alter case_141
.param LEN=4000 RUNIT=0.34 CCUNIT=0.1 CGUNIT=0.04 CSUNIT=0.14 CEN=1 LEFT=2 RIGHT=-1 WNBASE=.5u WPBASE=1.5u LBASE=.18u
.temp 27

.alter case_142
.param LEN=6000 RUNIT=0.34 CCUNIT=0.1 CGUNIT=0.04 CSUNIT=0.14 CEN=1 LEFT=2 RIGHT=-1 WNBASE=.5u WPBASE=1.5u LBASE=.18u
.temp 27

.alter case_143
.param LEN=8000 RUNIT=0.34 CCUNIT=0.1 CGUNIT=0.04 CSUNIT=0.14 CEN=1 LEFT=2 RIGHT=-1 WNBASE=.5u WPBASE=1.5u LBASE=.18u
.temp 27

.alter case_144
.param LEN=10000 RUNIT=0.34 CCUNIT=0.1 CGUNIT=0.04 CSUNIT=0.14 CEN=1 LEFT=2 RIGHT=-1 WNBASE=.5u WPBASE=1.5u LBASE=.18u
.temp 27

.alter case_145
.param LEN=2000 RUNIT=0.34 CCUNIT=0.1 CGUNIT=0.04 CSUNIT=0.14 CEN=1 LEFT=-1 RIGHT=-1 WNBASE=.5u WPBASE=1.5u LBASE=.18u
.temp 27

.alter case_146
.param LEN=4000 RUNIT=0.34 CCUNIT=0.1 CGUNIT=0.04 CSUNIT=0.14 CEN=1 LEFT=-1 RIGHT=-1 WNBASE=.5u WPBASE=1.5u LBASE=.18u
.temp 27

.alter case_147
.param LEN=6000 RUNIT=0.34 CCUNIT=0.1 CGUNIT=0.04 CSUNIT=0.14 CEN=1 LEFT=-1 RIGHT=-1 WNBASE=.5u WPBASE=1.5u LBASE=.18u
.temp 27

.alter case_148
.param LEN=8000 RUNIT=0.34 CCUNIT=0.1 CGUNIT=0.04 CSUNIT=0.14 CEN=1 LEFT=-1 RIGHT=-1 WNBASE=.5u WPBASE=1.5u LBASE=.18u
.temp 27

.alter case_149
.param LEN=10000 RUNIT=0.34 CCUNIT=0.1 CGUNIT=0.04 CSUNIT=0.14 CEN=1 LEFT=-1 RIGHT=-1 WNBASE=.5u WPBASE=1.5u LBASE=.18u
.temp 27

.alter case_150
.param LEN=2000 RUNIT=0.34 CCUNIT=0.1 CGUNIT=0.04 CSUNIT=0.14 CEN=-1 LEFT=1 RIGHT=1 WNBASE=.5u WPBASE=1.5u LBASE=.18u
.temp 27

.alter case_151
.param LEN=4000 RUNIT=0.34 CCUNIT=0.1 CGUNIT=0.04 CSUNIT=0.14 CEN=-1 LEFT=1 RIGHT=1 WNBASE=.5u WPBASE=1.5u LBASE=.18u
.temp 27

.alter case_152
.param LEN=6000 RUNIT=0.34 CCUNIT=0.1 CGUNIT=0.04 CSUNIT=0.14 CEN=-1 LEFT=1 RIGHT=1 WNBASE=.5u WPBASE=1.5u LBASE=.18u
.temp 27

.alter case_153
.param LEN=8000 RUNIT=0.34 CCUNIT=0.1 CGUNIT=0.04 CSUNIT=0.14 CEN=-1 LEFT=1 RIGHT=1 WNBASE=.5u WPBASE=1.5u LBASE=.18u
.temp 27

.alter case_154
.param LEN=10000 RUNIT=0.34 CCUNIT=0.1 CGUNIT=0.04 CSUNIT=0.14 CEN=-1 LEFT=1 RIGHT=1 WNBASE=.5u WPBASE=1.5u LBASE=.18u
.temp 27

.alter case_155
.param LEN=2000 RUNIT=0.34 CCUNIT=0.1 CGUNIT=0.04 CSUNIT=0.14 CEN=-1 LEFT=1 RIGHT=2 WNBASE=.5u WPBASE=1.5u LBASE=.18u
.temp 27

.alter case_156
.param LEN=4000 RUNIT=0.34 CCUNIT=0.1 CGUNIT=0.04 CSUNIT=0.14 CEN=-1 LEFT=1 RIGHT=2 WNBASE=.5u WPBASE=1.5u LBASE=.18u
.temp 27

.alter case_157
.param LEN=6000 RUNIT=0.34 CCUNIT=0.1 CGUNIT=0.04 CSUNIT=0.14 CEN=-1 LEFT=1 RIGHT=2 WNBASE=.5u WPBASE=1.5u LBASE=.18u
.temp 27

.alter case_158
.param LEN=8000 RUNIT=0.34 CCUNIT=0.1 CGUNIT=0.04 CSUNIT=0.14 CEN=-1 LEFT=1 RIGHT=2 WNBASE=.5u WPBASE=1.5u LBASE=.18u
.temp 27

.alter case_159
.param LEN=10000 RUNIT=0.34 CCUNIT=0.1 CGUNIT=0.04 CSUNIT=0.14 CEN=-1 LEFT=1 RIGHT=2 WNBASE=.5u WPBASE=1.5u LBASE=.18u
.temp 27

.alter case_160
.param LEN=2000 RUNIT=0.34 CCUNIT=0.1 CGUNIT=0.04 CSUNIT=0.14 CEN=-1 LEFT=1 RIGHT=-1 WNBASE=.5u WPBASE=1.5u LBASE=.18u
.temp 27

.alter case_161
.param LEN=4000 RUNIT=0.34 CCUNIT=0.1 CGUNIT=0.04 CSUNIT=0.14 CEN=-1 LEFT=1 RIGHT=-1 WNBASE=.5u WPBASE=1.5u LBASE=.18u
.temp 27

.alter case_162
.param LEN=6000 RUNIT=0.34 CCUNIT=0.1 CGUNIT=0.04 CSUNIT=0.14 CEN=-1 LEFT=1 RIGHT=-1 WNBASE=.5u WPBASE=1.5u LBASE=.18u
.temp 27

.alter case_163
.param LEN=8000 RUNIT=0.34 CCUNIT=0.1 CGUNIT=0.04 CSUNIT=0.14 CEN=-1 LEFT=1 RIGHT=-1 WNBASE=.5u WPBASE=1.5u LBASE=.18u
.temp 27

.alter case_164
.param LEN=10000 RUNIT=0.34 CCUNIT=0.1 CGUNIT=0.04 CSUNIT=0.14 CEN=-1 LEFT=1 RIGHT=-1 WNBASE=.5u WPBASE=1.5u LBASE=.18u
.temp 27

.alter case_165
.param LEN=2000 RUNIT=0.34 CCUNIT=0.1 CGUNIT=0.04 CSUNIT=0.14 CEN=-1 LEFT=2 RIGHT=2 WNBASE=.5u WPBASE=1.5u LBASE=.18u
.temp 27

.alter case_166
.param LEN=4000 RUNIT=0.34 CCUNIT=0.1 CGUNIT=0.04 CSUNIT=0.14 CEN=-1 LEFT=2 RIGHT=2 WNBASE=.5u WPBASE=1.5u LBASE=.18u
.temp 27

.alter case_167
.param LEN=6000 RUNIT=0.34 CCUNIT=0.1 CGUNIT=0.04 CSUNIT=0.14 CEN=-1 LEFT=2 RIGHT=2 WNBASE=.5u WPBASE=1.5u LBASE=.18u
.temp 27

.alter case_168
.param LEN=8000 RUNIT=0.34 CCUNIT=0.1 CGUNIT=0.04 CSUNIT=0.14 CEN=-1 LEFT=2 RIGHT=2 WNBASE=.5u WPBASE=1.5u LBASE=.18u
.temp 27

.alter case_169
.param LEN=10000 RUNIT=0.34 CCUNIT=0.1 CGUNIT=0.04 CSUNIT=0.14 CEN=-1 LEFT=2 RIGHT=2 WNBASE=.5u WPBASE=1.5u LBASE=.18u
.temp 27

.alter case_170
.param LEN=2000 RUNIT=0.34 CCUNIT=0.1 CGUNIT=0.04 CSUNIT=0.14 CEN=-1 LEFT=2 RIGHT=-1 WNBASE=.5u WPBASE=1.5u LBASE=.18u
.temp 27

.alter case_171
.param LEN=4000 RUNIT=0.34 CCUNIT=0.1 CGUNIT=0.04 CSUNIT=0.14 CEN=-1 LEFT=2 RIGHT=-1 WNBASE=.5u WPBASE=1.5u LBASE=.18u
.temp 27

.alter case_172
.param LEN=6000 RUNIT=0.34 CCUNIT=0.1 CGUNIT=0.04 CSUNIT=0.14 CEN=-1 LEFT=2 RIGHT=-1 WNBASE=.5u WPBASE=1.5u LBASE=.18u
.temp 27

.alter case_173
.param LEN=8000 RUNIT=0.34 CCUNIT=0.1 CGUNIT=0.04 CSUNIT=0.14 CEN=-1 LEFT=2 RIGHT=-1 WNBASE=.5u WPBASE=1.5u LBASE=.18u
.temp 27

.alter case_174
.param LEN=10000 RUNIT=0.34 CCUNIT=0.1 CGUNIT=0.04 CSUNIT=0.14 CEN=-1 LEFT=2 RIGHT=-1 WNBASE=.5u WPBASE=1.5u LBASE=.18u
.temp 27

.alter case_175
.param LEN=2000 RUNIT=0.34 CCUNIT=0.1 CGUNIT=0.04 CSUNIT=0.14 CEN=-1 LEFT=-1 RIGHT=-1 WNBASE=.5u WPBASE=1.5u LBASE=.18u
.temp 27

.alter case_176
.param LEN=4000 RUNIT=0.34 CCUNIT=0.1 CGUNIT=0.04 CSUNIT=0.14 CEN=-1 LEFT=-1 RIGHT=-1 WNBASE=.5u WPBASE=1.5u LBASE=.18u
.temp 27

.alter case_177
.param LEN=6000 RUNIT=0.34 CCUNIT=0.1 CGUNIT=0.04 CSUNIT=0.14 CEN=-1 LEFT=-1 RIGHT=-1 WNBASE=.5u WPBASE=1.5u LBASE=.18u
.temp 27

.alter case_178
.param LEN=8000 RUNIT=0.34 CCUNIT=0.1 CGUNIT=0.04 CSUNIT=0.14 CEN=-1 LEFT=-1 RIGHT=-1 WNBASE=.5u WPBASE=1.5u LBASE=.18u
.temp 27

.alter case_179
.param LEN=10000 RUNIT=0.34 CCUNIT=0.1 CGUNIT=0.04 CSUNIT=0.14 CEN=-1 LEFT=-1 RIGHT=-1 WNBASE=.5u WPBASE=1.5u LBASE=.18u
.temp 27

.end
